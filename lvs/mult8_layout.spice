* NGSPICE file created from mult8.ext - technology: sky130A

.subckt carry1 A Cob VSS Cout VDD Ci B
X0 VDD B a_4320_120# VDD sky130_fd_pr__pfet_01v8 ad=0.5 pd=2 as=0.5 ps=2 w=1 l=0.4
X1 Cob Ci a_3180_120# VDD sky130_fd_pr__pfet_01v8 ad=0.5 pd=2 as=0.5 ps=2 w=1 l=0.4
X2 VDD A a_3180_120# VDD sky130_fd_pr__pfet_01v8 ad=0.5 pd=2 as=1.1 ps=4.2 w=1 l=0.4
X3 a_3180_120# B VDD VDD sky130_fd_pr__pfet_01v8 ad=0.5 pd=2 as=0.5 ps=2 w=1 l=0.4
X4 a_4320_120# A Cob VDD sky130_fd_pr__pfet_01v8 ad=0.5 pd=2 as=0.5 ps=2 w=1 l=0.4
X5 Cout Cob VSS VSS sky130_fd_pr__nfet_01v8 ad=0.63 pd=3.2 as=0.35 ps=1.7 w=0.7 l=0.4
X6 VSS A a_3160_n360# VSS sky130_fd_pr__nfet_01v8 ad=0.35 pd=1.7 as=0.84 ps=3.8 w=0.7 l=0.4
X7 Cob Ci a_3160_n360# VSS sky130_fd_pr__nfet_01v8 ad=0.35 pd=1.7 as=0.35 ps=1.7 w=0.7 l=0.4
X8 Cout Cob VDD VDD sky130_fd_pr__pfet_01v8 ad=0.9 pd=3.8 as=0.5 ps=2 w=1 l=0.4
X9 VSS B a_4320_n360# VSS sky130_fd_pr__nfet_01v8 ad=0.35 pd=1.7 as=0.35 ps=1.7 w=0.7 l=0.4
X10 a_3160_n360# B VSS VSS sky130_fd_pr__nfet_01v8 ad=0.35 pd=1.7 as=0.35 ps=1.7 w=0.7 l=0.4
X11 a_4320_n360# A Cob VSS sky130_fd_pr__nfet_01v8 ad=0.35 pd=1.7 as=0.35 ps=1.7 w=0.7 l=0.4
.ends

.subckt sum_backup A B Ci Cob S_out VDD VSS
X0 a_7020_n360# Cob a_6300_n360# VSS sky130_fd_pr__nfet_01v8 ad=0.28 pd=1.5 as=0.28 ps=1.5 w=0.7 l=0.4
X1 a_7260_120# A a_7020_n360# VDD sky130_fd_pr__pfet_01v8 ad=0.4 pd=1.8 as=0.4 ps=1.8 w=1 l=0.4
X2 VDD Ci a_7500_120# VDD sky130_fd_pr__pfet_01v8 ad=1 pd=3 as=0.4 ps=1.8 w=1 l=0.4
X3 VSS Ci a_7500_n360# VSS sky130_fd_pr__nfet_01v8 ad=0.7 pd=2.7 as=0.28 ps=1.5 w=0.7 l=0.4
X4 a_6300_n360# A VSS VSS sky130_fd_pr__nfet_01v8 ad=0.28 pd=1.5 as=0.77 ps=3.6 w=0.7 l=0.4
X5 a_6300_120# A VDD VDD sky130_fd_pr__pfet_01v8 ad=0.4 pd=1.8 as=1.1 ps=4.2 w=1 l=0.4
X6 a_6300_120# Ci VDD VDD sky130_fd_pr__pfet_01v8 ad=0.4 pd=1.8 as=0.4 ps=1.8 w=1 l=0.4
X7 VSS B a_6300_n360# VSS sky130_fd_pr__nfet_01v8 ad=0.28 pd=1.5 as=0.28 ps=1.5 w=0.7 l=0.4
X8 a_7500_120# B a_7260_120# VDD sky130_fd_pr__pfet_01v8 ad=0.4 pd=1.8 as=0.4 ps=1.8 w=1 l=0.4
X9 a_7260_n360# A a_7020_n360# VSS sky130_fd_pr__nfet_01v8 ad=0.28 pd=1.5 as=0.28 ps=1.5 w=0.7 l=0.4
X10 a_6300_n360# Ci VSS VSS sky130_fd_pr__nfet_01v8 ad=0.28 pd=1.5 as=0.28 ps=1.5 w=0.7 l=0.4
X11 a_7500_n360# B a_7260_n360# VSS sky130_fd_pr__nfet_01v8 ad=0.28 pd=1.5 as=0.28 ps=1.5 w=0.7 l=0.4
X12 S_out a_7020_n360# VSS VSS sky130_fd_pr__nfet_01v8 ad=0.77 pd=3.6 as=0.7 ps=2.7 w=0.7 l=0.4
X13 S_out a_7020_n360# VDD VDD sky130_fd_pr__pfet_01v8 ad=1.7 pd=5.4 as=1 ps=3 w=1 l=0.4
X14 VDD B a_6300_120# VDD sky130_fd_pr__pfet_01v8 ad=0.4 pd=1.8 as=0.4 ps=1.8 w=1 l=0.4
X15 a_7020_n360# Cob a_6300_120# VDD sky130_fd_pr__pfet_01v8 ad=0.4 pd=1.8 as=0.4 ps=1.8 w=1 l=0.4
.ends

.subckt pp_and2 VDD VSS a b pp
X0 a_240_n360# a a_n80_n360# VSS sky130_fd_pr__nfet_01v8 ad=0.49 pd=2.1 as=0.84 ps=3.8 w=0.7 l=0.4
X1 VSS b a_240_n360# VSS sky130_fd_pr__nfet_01v8 ad=0.455 pd=2 as=0.49 ps=2.1 w=0.7 l=0.4
X2 pp a_n80_n360# VSS VSS sky130_fd_pr__nfet_01v8 ad=1.89 pd=6.8 as=0.455 ps=2 w=0.7 l=0.4
X3 VDD b a_n80_n360# VDD sky130_fd_pr__pfet_01v8 ad=0.65 pd=2.3 as=0.7 ps=2.4 w=1 l=0.4
X4 pp a_n80_n360# VDD VDD sky130_fd_pr__pfet_01v8 ad=2.7 pd=7.4 as=0.65 ps=2.3 w=1 l=0.4
X5 a_n80_n360# a VDD VDD sky130_fd_pr__pfet_01v8 ad=0.7 pd=2.4 as=1.2 ps=4.4 w=1 l=0.4
.ends

.subckt pp_cell C_out S_out c_in s_in b_j a_i VDD VSS
Xcarry1_0 carry1_0/A carry1_0/Cob VSS C_out VDD c_in s_in carry1
Xsum_backup_0 carry1_0/A s_in c_in carry1_0/Cob S_out VDD VSS sum_backup
Xpp_and2_0 VDD VSS a_i b_j carry1_0/A pp_and2
.ends

.subckt pp_cell_sign C_out S_out c_in s_in b_j a_i VSS VDD
Xcarry1_0 carry1_0/A carry1_0/Cob VSS C_out VDD c_in s_in carry1
Xsum_backup_0 carry1_0/A s_in c_in carry1_0/Cob S_out VDD VSS sum_backup
X0 VSS b_j a_n900_n420# VSS sky130_fd_pr__nfet_01v8 ad=0.77 pd=3.6 as=0.49 ps=2.1 w=0.7 l=0.4
X1 VDD b_j carry1_0/A VDD sky130_fd_pr__pfet_01v8 ad=4.4 pd=10.8 as=0.7 ps=2.4 w=1 l=0.4
X2 a_n900_n420# a_i carry1_0/A VSS sky130_fd_pr__nfet_01v8 ad=0.49 pd=2.1 as=0.84 ps=3.8 w=0.7 l=0.4
X3 carry1_0/A a_i VDD VDD sky130_fd_pr__pfet_01v8 ad=0.7 pd=2.4 as=1.2 ps=4.4 w=1 l=0.4
.ends

.subckt row_7 a6 a5 a4 a3 a2 a1 a0 sout7 sout6 sout5 sout4 sout3 sout2 sout1 sout0
+ a7 VDD cout b sin7 sin6 sin5 sin4 sin3 sin2 sin1 sin0 pp_cell_sign_5/c_in pp_cell_sign_4/c_in
+ pp_cell_sign_0/c_in pp_cell_sign_2/c_in pp_cell_7/c_in pp_cell_sign_1/c_in pp_cell_sign_3/c_in
+ VSS
Xpp_cell_7 cout sout7 pp_cell_7/c_in sin7 b a7 VDD VSS pp_cell
Xpp_cell_sign_0 pp_cell_7/c_in sout6 pp_cell_sign_0/c_in sin6 b a6 VSS VDD pp_cell_sign
Xpp_cell_sign_1 pp_cell_sign_0/c_in sout5 pp_cell_sign_1/c_in sin5 b a5 VSS VDD pp_cell_sign
Xpp_cell_sign_2 pp_cell_sign_1/c_in sout4 pp_cell_sign_2/c_in sin4 b a4 VSS VDD pp_cell_sign
Xpp_cell_sign_3 pp_cell_sign_2/c_in sout3 pp_cell_sign_3/c_in sin3 b a3 VSS VDD pp_cell_sign
Xpp_cell_sign_4 pp_cell_sign_3/c_in sout2 pp_cell_sign_4/c_in sin2 b a2 VSS VDD pp_cell_sign
Xpp_cell_sign_5 pp_cell_sign_4/c_in sout1 pp_cell_sign_5/c_in sin1 b a1 VSS VDD pp_cell_sign
Xpp_cell_sign_6 pp_cell_sign_5/c_in sout0 VSS sin0 b a0 VSS VDD pp_cell_sign
.ends

.subckt row_1_test_label_fix sout7 sout6 b sin7 sin6 sin5 sin3 sin2 sin1 sin0 pp_cell_5/c_in
+ sout5 pp_cell_4/c_in sout4 sout3 pp_cell_0/c_in a6 a5 a4 a3 a2 sout2 a1 a0 pp_cell_2/c_in
+ a7 pp_cell_1/c_in sout1 sin4 sout0 pp_cell_0/C_out cout VDD pp_cell_3/c_in VSS
Xpp_cell_0 pp_cell_0/C_out sout6 pp_cell_0/c_in sin6 b a6 VDD VSS pp_cell
Xpp_cell_1 pp_cell_0/c_in sout5 pp_cell_1/c_in sin5 b a5 VDD VSS pp_cell
Xpp_cell_2 pp_cell_1/c_in sout4 pp_cell_2/c_in sin4 b a4 VDD VSS pp_cell
Xpp_cell_3 pp_cell_2/c_in sout3 pp_cell_3/c_in sin3 b a3 VDD VSS pp_cell
Xpp_cell_4 pp_cell_3/c_in sout2 pp_cell_4/c_in sin2 b a2 VDD VSS pp_cell
Xpp_cell_5 pp_cell_4/c_in sout1 pp_cell_5/c_in sin1 b a1 VDD VSS pp_cell
Xpp_cell_6 pp_cell_5/c_in sout0 VSS sin0 b a0 VDD VSS pp_cell
Xpp_cell_sign_0 cout sout7 pp_cell_0/C_out sin7 b a7 VSS VDD pp_cell_sign
.ends

.subckt nand2 VDD VSS a b pp
X0 a_240_n360# a pp VSS sky130_fd_pr__nfet_01v8 ad=0.49 pd=2.1 as=0.84 ps=3.8 w=0.7 l=0.4
X1 VSS b a_240_n360# VSS sky130_fd_pr__nfet_01v8 ad=3.08 pd=10.2 as=0.49 ps=2.1 w=0.7 l=0.4
X2 VDD b pp VDD sky130_fd_pr__pfet_01v8 ad=4.4 pd=10.8 as=0.7 ps=2.4 w=1 l=0.4
X3 pp a VDD VDD sky130_fd_pr__pfet_01v8 ad=0.7 pd=2.4 as=1.2 ps=4.4 w=1 l=0.4
.ends

.subckt mult8 P0 P1 P2 P3 P4 P5 P6 P7 P8 P9 P10 P11 P12 P13 P14 P15 a7 a6 a5 a4 a3
+ a2 a1 a0
Xrow_7_0 a6 a5 a4 a3 a2 a1 a0 P14 P13 P12 P11 P10 P9 P8 P7 a7 row_7_0/VDD nand2_0/b
+ row_7_0/b row_7_0/sin7 row_7_0/sin6 row_7_0/sin5 row_7_0/sin4 row_7_0/sin3 row_7_0/sin2
+ row_7_0/sin1 row_7_0/sin0 row_7_0/pp_cell_sign_5/c_in row_7_0/pp_cell_sign_4/c_in
+ row_7_0/pp_cell_sign_0/c_in row_7_0/pp_cell_sign_2/c_in row_7_0/pp_cell_7/c_in row_7_0/pp_cell_sign_1/c_in
+ row_7_0/pp_cell_sign_3/c_in VSUBS row_7
Xrow_1_test_label_fix_0 row_1_test_label_fix_1/sin6 row_1_test_label_fix_1/sin5 row_1_test_label_fix_0/b
+ VSUBS VSUBS VSUBS VSUBS VSUBS VSUBS VSUBS row_1_test_label_fix_0/pp_cell_5/c_in
+ row_1_test_label_fix_1/sin4 row_1_test_label_fix_0/pp_cell_4/c_in row_1_test_label_fix_1/sin3
+ row_1_test_label_fix_1/sin2 row_1_test_label_fix_0/pp_cell_0/c_in a6 a5 a4 a3 a2
+ row_1_test_label_fix_1/sin1 a1 a0 row_1_test_label_fix_0/pp_cell_2/c_in a7 row_1_test_label_fix_0/pp_cell_1/c_in
+ row_1_test_label_fix_1/sin0 VSUBS P0 row_1_test_label_fix_0/pp_cell_0/C_out row_1_test_label_fix_0/cout
+ row_7_0/VDD row_1_test_label_fix_0/pp_cell_3/c_in VSUBS row_1_test_label_fix
Xrow_1_test_label_fix_1 row_1_test_label_fix_2/sin6 row_1_test_label_fix_2/sin5 row_1_test_label_fix_1/b
+ row_7_0/VDD row_1_test_label_fix_1/sin6 row_1_test_label_fix_1/sin5 row_1_test_label_fix_1/sin3
+ row_1_test_label_fix_1/sin2 row_1_test_label_fix_1/sin1 row_1_test_label_fix_1/sin0
+ row_1_test_label_fix_1/pp_cell_5/c_in row_1_test_label_fix_2/sin4 row_1_test_label_fix_1/pp_cell_4/c_in
+ row_1_test_label_fix_2/sin3 row_1_test_label_fix_2/sin2 row_1_test_label_fix_1/pp_cell_0/c_in
+ a6 a5 a4 a3 a2 row_1_test_label_fix_2/sin1 a1 a0 row_1_test_label_fix_1/pp_cell_2/c_in
+ a7 row_1_test_label_fix_1/pp_cell_1/c_in row_1_test_label_fix_2/sin0 row_1_test_label_fix_1/sin4
+ P1 row_1_test_label_fix_1/pp_cell_0/C_out row_1_test_label_fix_2/sin7 row_7_0/VDD
+ row_1_test_label_fix_1/pp_cell_3/c_in VSUBS row_1_test_label_fix
Xrow_1_test_label_fix_2 row_1_test_label_fix_3/sin6 row_1_test_label_fix_3/sin5 row_1_test_label_fix_2/b
+ row_1_test_label_fix_2/sin7 row_1_test_label_fix_2/sin6 row_1_test_label_fix_2/sin5
+ row_1_test_label_fix_2/sin3 row_1_test_label_fix_2/sin2 row_1_test_label_fix_2/sin1
+ row_1_test_label_fix_2/sin0 row_1_test_label_fix_2/pp_cell_5/c_in row_1_test_label_fix_3/sin4
+ row_1_test_label_fix_2/pp_cell_4/c_in row_1_test_label_fix_3/sin3 row_1_test_label_fix_3/sin2
+ row_1_test_label_fix_2/pp_cell_0/c_in a6 a5 a4 a3 a2 row_1_test_label_fix_3/sin1
+ a1 a0 row_1_test_label_fix_2/pp_cell_2/c_in a7 row_1_test_label_fix_2/pp_cell_1/c_in
+ row_1_test_label_fix_3/sin0 row_1_test_label_fix_2/sin4 P2 row_1_test_label_fix_2/pp_cell_0/C_out
+ row_1_test_label_fix_3/sin7 row_7_0/VDD row_1_test_label_fix_2/pp_cell_3/c_in VSUBS
+ row_1_test_label_fix
Xrow_1_test_label_fix_3 row_1_test_label_fix_4/sin6 row_1_test_label_fix_4/sin5 row_1_test_label_fix_3/b
+ row_1_test_label_fix_3/sin7 row_1_test_label_fix_3/sin6 row_1_test_label_fix_3/sin5
+ row_1_test_label_fix_3/sin3 row_1_test_label_fix_3/sin2 row_1_test_label_fix_3/sin1
+ row_1_test_label_fix_3/sin0 row_1_test_label_fix_3/pp_cell_5/c_in row_1_test_label_fix_4/sin4
+ row_1_test_label_fix_3/pp_cell_4/c_in row_1_test_label_fix_4/sin3 row_1_test_label_fix_4/sin2
+ row_1_test_label_fix_3/pp_cell_0/c_in a6 a5 a4 a3 a2 row_1_test_label_fix_4/sin1
+ a1 a0 row_1_test_label_fix_3/pp_cell_2/c_in a7 row_1_test_label_fix_3/pp_cell_1/c_in
+ row_1_test_label_fix_4/sin0 row_1_test_label_fix_3/sin4 P3 row_1_test_label_fix_3/pp_cell_0/C_out
+ row_1_test_label_fix_4/sin7 row_7_0/VDD row_1_test_label_fix_3/pp_cell_3/c_in VSUBS
+ row_1_test_label_fix
Xrow_1_test_label_fix_4 row_1_test_label_fix_5/sin6 row_1_test_label_fix_5/sin5 row_1_test_label_fix_4/b
+ row_1_test_label_fix_4/sin7 row_1_test_label_fix_4/sin6 row_1_test_label_fix_4/sin5
+ row_1_test_label_fix_4/sin3 row_1_test_label_fix_4/sin2 row_1_test_label_fix_4/sin1
+ row_1_test_label_fix_4/sin0 row_1_test_label_fix_4/pp_cell_5/c_in row_1_test_label_fix_5/sin4
+ row_1_test_label_fix_4/pp_cell_4/c_in row_1_test_label_fix_5/sin3 row_1_test_label_fix_5/sin2
+ row_1_test_label_fix_4/pp_cell_0/c_in a6 a5 a4 a3 a2 row_1_test_label_fix_5/sin1
+ a1 a0 row_1_test_label_fix_4/pp_cell_2/c_in a7 row_1_test_label_fix_4/pp_cell_1/c_in
+ row_1_test_label_fix_5/sin0 row_1_test_label_fix_4/sin4 P4 row_1_test_label_fix_4/pp_cell_0/C_out
+ row_1_test_label_fix_5/sin7 row_7_0/VDD row_1_test_label_fix_4/pp_cell_3/c_in VSUBS
+ row_1_test_label_fix
Xrow_1_test_label_fix_5 row_1_test_label_fix_6/sin6 row_1_test_label_fix_6/sin5 row_1_test_label_fix_5/b
+ row_1_test_label_fix_5/sin7 row_1_test_label_fix_5/sin6 row_1_test_label_fix_5/sin5
+ row_1_test_label_fix_5/sin3 row_1_test_label_fix_5/sin2 row_1_test_label_fix_5/sin1
+ row_1_test_label_fix_5/sin0 row_1_test_label_fix_5/pp_cell_5/c_in row_1_test_label_fix_6/sin4
+ row_1_test_label_fix_5/pp_cell_4/c_in row_1_test_label_fix_6/sin3 row_1_test_label_fix_6/sin2
+ row_1_test_label_fix_5/pp_cell_0/c_in a6 a5 a4 a3 a2 row_1_test_label_fix_6/sin1
+ a1 a0 row_1_test_label_fix_5/pp_cell_2/c_in a7 row_1_test_label_fix_5/pp_cell_1/c_in
+ row_1_test_label_fix_6/sin0 row_1_test_label_fix_5/sin4 P5 row_1_test_label_fix_5/pp_cell_0/C_out
+ row_1_test_label_fix_6/sin7 row_7_0/VDD row_1_test_label_fix_5/pp_cell_3/c_in VSUBS
+ row_1_test_label_fix
Xrow_1_test_label_fix_6 row_7_0/sin6 row_7_0/sin5 row_1_test_label_fix_6/b row_1_test_label_fix_6/sin7
+ row_1_test_label_fix_6/sin6 row_1_test_label_fix_6/sin5 row_1_test_label_fix_6/sin3
+ row_1_test_label_fix_6/sin2 row_1_test_label_fix_6/sin1 row_1_test_label_fix_6/sin0
+ row_1_test_label_fix_6/pp_cell_5/c_in row_7_0/sin4 row_1_test_label_fix_6/pp_cell_4/c_in
+ row_7_0/sin3 row_7_0/sin2 row_1_test_label_fix_6/pp_cell_0/c_in a6 a5 a4 a3 a2 row_7_0/sin1
+ a1 a0 row_1_test_label_fix_6/pp_cell_2/c_in a7 row_1_test_label_fix_6/pp_cell_1/c_in
+ row_7_0/sin0 row_1_test_label_fix_6/sin4 P6 row_1_test_label_fix_6/pp_cell_0/C_out
+ row_7_0/sin7 row_7_0/VDD row_1_test_label_fix_6/pp_cell_3/c_in VSUBS row_1_test_label_fix
Xnand2_0 row_7_0/VDD VSUBS nand2_0/b nand2_0/b P15 nand2
.ends
