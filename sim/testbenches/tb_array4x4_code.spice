.include /foss/pdks/sky130A/libs.ref/sky130_fd_sc_hd/spice/sky130_fd_sc_hd.spice
.tran 0.1n 140n uic

* ===== inputs: A rows enter on the left (ah_0), B columns on top (bv0_) =====
* row 0 of A, staircase starts tick 5
Vah00_0 ah00[0] 0 PWL(0 0 36n 0 36.1n 1.8 46n 1.8 46.1n 0 56n 0 56.1n 1.8 66n 1.8 66.1n 0)
Vah00_1 ah00[1] 0 PWL(0 0 46n 0 46.1n 1.8 66n 1.8 66.1n 0)
Vah00_2 ah00[2] 0 PWL(0 0 46n 0 46.1n 1.8 56n 1.8 56.1n 0)
Vah00_3 ah00[3] 0 PWL(0 0 46n 0 46.1n 1.8 56n 1.8 56.1n 0)
Vah00_4 ah00[4] 0 PWL(0 0 46n 0 46.1n 1.8 56n 1.8 56.1n 0)
Vah00_5 ah00[5] 0 PWL(0 0 46n 0 46.1n 1.8 56n 1.8 56.1n 0)
Vah00_6 ah00[6] 0 PWL(0 0 46n 0 46.1n 1.8 56n 1.8 56.1n 0)
Vah00_7 ah00[7] 0 PWL(0 0 46n 0 46.1n 1.8 56n 1.8 56.1n 0)
* row 1 of A, staircase starts tick 6
Vah10_0 ah10[0] 0 PWL(0 0 56n 0 56.1n 1.8 76n 1.8 76.1n 0)
Vah10_1 ah10[1] 0 PWL(0 0 46n 0 46.1n 1.8 56n 1.8 56.1n 0 66n 0 66.1n 1.8 76n 1.8 76.1n 0)
Vah10_2 ah10[2] 0 PWL(0 0 66n 0 66.1n 1.8 86n 1.8 86.1n 0)
Vah10_3 ah10[3] 0 PWL(0 0 66n 0 66.1n 1.8 76n 1.8 76.1n 0)
Vah10_4 ah10[4] 0 PWL(0 0 66n 0 66.1n 1.8 76n 1.8 76.1n 0)
Vah10_5 ah10[5] 0 PWL(0 0 66n 0 66.1n 1.8 76n 1.8 76.1n 0)
Vah10_6 ah10[6] 0 PWL(0 0 66n 0 66.1n 1.8 76n 1.8 76.1n 0)
Vah10_7 ah10[7] 0 PWL(0 0 66n 0 66.1n 1.8 76n 1.8 76.1n 0)
* row 2 of A, staircase starts tick 7
Vah20_0 ah20[0] 0 PWL(0 0 56n 0 56.1n 1.8 66n 1.8 66.1n 0 86n 0 86.1n 1.8 96n 1.8 96.1n 0)
Vah20_1 ah20[1] 0 PWL(0 0 76n 0 76.1n 1.8 86n 1.8 86.1n 0)
Vah20_2 ah20[2] 0 PWL(0 0 56n 0 56.1n 1.8 66n 1.8 66.1n 0)
Vah20_3 ah20[3] 0 PWL(0 0 56n 0 56.1n 1.8 66n 1.8 66.1n 0)
Vah20_4 ah20[4] 0 PWL(0 0 56n 0 56.1n 1.8 66n 1.8 66.1n 0)
Vah20_5 ah20[5] 0 PWL(0 0 56n 0 56.1n 1.8 66n 1.8 66.1n 0)
Vah20_6 ah20[6] 0 PWL(0 0 56n 0 56.1n 1.8 66n 1.8 66.1n 0)
Vah20_7 ah20[7] 0 PWL(0 0 56n 0 56.1n 1.8 66n 1.8 66.1n 0)
* row 3 of A, staircase starts tick 8
Vah30_0 ah30[0] 0 PWL(0 0 66n 0 66.1n 1.8 106n 1.8 106.1n 0)
Vah30_1 ah30[1] 0 0
Vah30_2 ah30[2] 0 0
Vah30_3 ah30[3] 0 0
Vah30_4 ah30[4] 0 0
Vah30_5 ah30[5] 0 0
Vah30_6 ah30[6] 0 0
Vah30_7 ah30[7] 0 0
* column 0 of B, staircase starts tick 5
Vbv00_0 bv00[0] 0 PWL(0 0 46n 0 46.1n 1.8 66n 1.8 66.1n 0)
Vbv00_1 bv00[1] 0 PWL(0 0 36n 0 36.1n 1.8 46n 1.8 46.1n 0 56n 0 56.1n 1.8 66n 1.8 66.1n 0)
Vbv00_2 bv00[2] 0 PWL(0 0 56n 0 56.1n 1.8 66n 1.8 66.1n 0)
Vbv00_3 bv00[3] 0 PWL(0 0 56n 0 56.1n 1.8 66n 1.8 66.1n 0)
Vbv00_4 bv00[4] 0 PWL(0 0 56n 0 56.1n 1.8 66n 1.8 66.1n 0)
Vbv00_5 bv00[5] 0 PWL(0 0 56n 0 56.1n 1.8 66n 1.8 66.1n 0)
Vbv00_6 bv00[6] 0 PWL(0 0 56n 0 56.1n 1.8 66n 1.8 66.1n 0)
Vbv00_7 bv00[7] 0 PWL(0 0 56n 0 56.1n 1.8 66n 1.8 66.1n 0)
* column 1 of B, staircase starts tick 6
Vbv01_0 bv01[0] 0 PWL(0 0 56n 0 56.1n 1.8 76n 1.8 76.1n 0)
Vbv01_1 bv01[1] 0 PWL(0 0 56n 0 56.1n 1.8 66n 1.8 66.1n 0 76n 0 76.1n 1.8 86n 1.8 86.1n 0)
Vbv01_2 bv01[2] 0 PWL(0 0 76n 0 76.1n 1.8 86n 1.8 86.1n 0)
Vbv01_3 bv01[3] 0 PWL(0 0 76n 0 76.1n 1.8 86n 1.8 86.1n 0)
Vbv01_4 bv01[4] 0 PWL(0 0 76n 0 76.1n 1.8 86n 1.8 86.1n 0)
Vbv01_5 bv01[5] 0 PWL(0 0 76n 0 76.1n 1.8 86n 1.8 86.1n 0)
Vbv01_6 bv01[6] 0 PWL(0 0 76n 0 76.1n 1.8 86n 1.8 86.1n 0)
Vbv01_7 bv01[7] 0 PWL(0 0 76n 0 76.1n 1.8 86n 1.8 86.1n 0)
* column 2 of B, staircase starts tick 7
Vbv02_0 bv02[0] 0 PWL(0 0 56n 0 56.1n 1.8 66n 1.8 66.1n 0 86n 0 86.1n 1.8 96n 1.8 96.1n 0)
Vbv02_1 bv02[1] 0 PWL(0 0 76n 0 76.1n 1.8 86n 1.8 86.1n 0)
Vbv02_2 bv02[2] 0 0
Vbv02_3 bv02[3] 0 0
Vbv02_4 bv02[4] 0 0
Vbv02_5 bv02[5] 0 0
Vbv02_6 bv02[6] 0 0
Vbv02_7 bv02[7] 0 0
* column 3 of B, staircase starts tick 8
Vbv03_0 bv03[0] 0 PWL(0 0 66n 0 66.1n 1.8 76n 1.8 76.1n 0 96n 0 96.1n 1.8 106n 1.8 106.1n 0)
Vbv03_1 bv03[1] 0 PWL(0 0 66n 0 66.1n 1.8 86n 1.8 86.1n 0 96n 0 96.1n 1.8 106n 1.8 106.1n 0)
Vbv03_2 bv03[2] 0 PWL(0 0 66n 0 66.1n 1.8 76n 1.8 76.1n 0)
Vbv03_3 bv03[3] 0 PWL(0 0 66n 0 66.1n 1.8 76n 1.8 76.1n 0)
Vbv03_4 bv03[4] 0 PWL(0 0 66n 0 66.1n 1.8 76n 1.8 76.1n 0)
Vbv03_5 bv03[5] 0 PWL(0 0 66n 0 66.1n 1.8 76n 1.8 76.1n 0)
Vbv03_6 bv03[6] 0 PWL(0 0 66n 0 66.1n 1.8 76n 1.8 76.1n 0)
Vbv03_7 bv03[7] 0 PWL(0 0 66n 0 66.1n 1.8 76n 1.8 76.1n 0)
* ===== plain-name copies of every ACC bit (ngspice can't plot [ ]) =====
E00_0 c00b0 0 c00[0] 0 1
E00_1 c00b1 0 c00[1] 0 1
E00_2 c00b2 0 c00[2] 0 1
E00_3 c00b3 0 c00[3] 0 1
E00_4 c00b4 0 c00[4] 0 1
E00_5 c00b5 0 c00[5] 0 1
E00_6 c00b6 0 c00[6] 0 1
E00_7 c00b7 0 c00[7] 0 1
E00_8 c00b8 0 c00[8] 0 1
E00_9 c00b9 0 c00[9] 0 1
E00_10 c00b10 0 c00[10] 0 1
E00_11 c00b11 0 c00[11] 0 1
E00_12 c00b12 0 c00[12] 0 1
E00_13 c00b13 0 c00[13] 0 1
E00_14 c00b14 0 c00[14] 0 1
E00_15 c00b15 0 c00[15] 0 1
E00_16 c00b16 0 c00[16] 0 1
E00_17 c00b17 0 c00[17] 0 1
E00_18 c00b18 0 c00[18] 0 1
E00_19 c00b19 0 c00[19] 0 1
E01_0 c01b0 0 c01[0] 0 1
E01_1 c01b1 0 c01[1] 0 1
E01_2 c01b2 0 c01[2] 0 1
E01_3 c01b3 0 c01[3] 0 1
E01_4 c01b4 0 c01[4] 0 1
E01_5 c01b5 0 c01[5] 0 1
E01_6 c01b6 0 c01[6] 0 1
E01_7 c01b7 0 c01[7] 0 1
E01_8 c01b8 0 c01[8] 0 1
E01_9 c01b9 0 c01[9] 0 1
E01_10 c01b10 0 c01[10] 0 1
E01_11 c01b11 0 c01[11] 0 1
E01_12 c01b12 0 c01[12] 0 1
E01_13 c01b13 0 c01[13] 0 1
E01_14 c01b14 0 c01[14] 0 1
E01_15 c01b15 0 c01[15] 0 1
E01_16 c01b16 0 c01[16] 0 1
E01_17 c01b17 0 c01[17] 0 1
E01_18 c01b18 0 c01[18] 0 1
E01_19 c01b19 0 c01[19] 0 1
E02_0 c02b0 0 c02[0] 0 1
E02_1 c02b1 0 c02[1] 0 1
E02_2 c02b2 0 c02[2] 0 1
E02_3 c02b3 0 c02[3] 0 1
E02_4 c02b4 0 c02[4] 0 1
E02_5 c02b5 0 c02[5] 0 1
E02_6 c02b6 0 c02[6] 0 1
E02_7 c02b7 0 c02[7] 0 1
E02_8 c02b8 0 c02[8] 0 1
E02_9 c02b9 0 c02[9] 0 1
E02_10 c02b10 0 c02[10] 0 1
E02_11 c02b11 0 c02[11] 0 1
E02_12 c02b12 0 c02[12] 0 1
E02_13 c02b13 0 c02[13] 0 1
E02_14 c02b14 0 c02[14] 0 1
E02_15 c02b15 0 c02[15] 0 1
E02_16 c02b16 0 c02[16] 0 1
E02_17 c02b17 0 c02[17] 0 1
E02_18 c02b18 0 c02[18] 0 1
E02_19 c02b19 0 c02[19] 0 1
E03_0 c03b0 0 c03[0] 0 1
E03_1 c03b1 0 c03[1] 0 1
E03_2 c03b2 0 c03[2] 0 1
E03_3 c03b3 0 c03[3] 0 1
E03_4 c03b4 0 c03[4] 0 1
E03_5 c03b5 0 c03[5] 0 1
E03_6 c03b6 0 c03[6] 0 1
E03_7 c03b7 0 c03[7] 0 1
E03_8 c03b8 0 c03[8] 0 1
E03_9 c03b9 0 c03[9] 0 1
E03_10 c03b10 0 c03[10] 0 1
E03_11 c03b11 0 c03[11] 0 1
E03_12 c03b12 0 c03[12] 0 1
E03_13 c03b13 0 c03[13] 0 1
E03_14 c03b14 0 c03[14] 0 1
E03_15 c03b15 0 c03[15] 0 1
E03_16 c03b16 0 c03[16] 0 1
E03_17 c03b17 0 c03[17] 0 1
E03_18 c03b18 0 c03[18] 0 1
E03_19 c03b19 0 c03[19] 0 1
E10_0 c10b0 0 c10[0] 0 1
E10_1 c10b1 0 c10[1] 0 1
E10_2 c10b2 0 c10[2] 0 1
E10_3 c10b3 0 c10[3] 0 1
E10_4 c10b4 0 c10[4] 0 1
E10_5 c10b5 0 c10[5] 0 1
E10_6 c10b6 0 c10[6] 0 1
E10_7 c10b7 0 c10[7] 0 1
E10_8 c10b8 0 c10[8] 0 1
E10_9 c10b9 0 c10[9] 0 1
E10_10 c10b10 0 c10[10] 0 1
E10_11 c10b11 0 c10[11] 0 1
E10_12 c10b12 0 c10[12] 0 1
E10_13 c10b13 0 c10[13] 0 1
E10_14 c10b14 0 c10[14] 0 1
E10_15 c10b15 0 c10[15] 0 1
E10_16 c10b16 0 c10[16] 0 1
E10_17 c10b17 0 c10[17] 0 1
E10_18 c10b18 0 c10[18] 0 1
E10_19 c10b19 0 c10[19] 0 1
E11_0 c11b0 0 c11[0] 0 1
E11_1 c11b1 0 c11[1] 0 1
E11_2 c11b2 0 c11[2] 0 1
E11_3 c11b3 0 c11[3] 0 1
E11_4 c11b4 0 c11[4] 0 1
E11_5 c11b5 0 c11[5] 0 1
E11_6 c11b6 0 c11[6] 0 1
E11_7 c11b7 0 c11[7] 0 1
E11_8 c11b8 0 c11[8] 0 1
E11_9 c11b9 0 c11[9] 0 1
E11_10 c11b10 0 c11[10] 0 1
E11_11 c11b11 0 c11[11] 0 1
E11_12 c11b12 0 c11[12] 0 1
E11_13 c11b13 0 c11[13] 0 1
E11_14 c11b14 0 c11[14] 0 1
E11_15 c11b15 0 c11[15] 0 1
E11_16 c11b16 0 c11[16] 0 1
E11_17 c11b17 0 c11[17] 0 1
E11_18 c11b18 0 c11[18] 0 1
E11_19 c11b19 0 c11[19] 0 1
E12_0 c12b0 0 c12[0] 0 1
E12_1 c12b1 0 c12[1] 0 1
E12_2 c12b2 0 c12[2] 0 1
E12_3 c12b3 0 c12[3] 0 1
E12_4 c12b4 0 c12[4] 0 1
E12_5 c12b5 0 c12[5] 0 1
E12_6 c12b6 0 c12[6] 0 1
E12_7 c12b7 0 c12[7] 0 1
E12_8 c12b8 0 c12[8] 0 1
E12_9 c12b9 0 c12[9] 0 1
E12_10 c12b10 0 c12[10] 0 1
E12_11 c12b11 0 c12[11] 0 1
E12_12 c12b12 0 c12[12] 0 1
E12_13 c12b13 0 c12[13] 0 1
E12_14 c12b14 0 c12[14] 0 1
E12_15 c12b15 0 c12[15] 0 1
E12_16 c12b16 0 c12[16] 0 1
E12_17 c12b17 0 c12[17] 0 1
E12_18 c12b18 0 c12[18] 0 1
E12_19 c12b19 0 c12[19] 0 1
E13_0 c13b0 0 c13[0] 0 1
E13_1 c13b1 0 c13[1] 0 1
E13_2 c13b2 0 c13[2] 0 1
E13_3 c13b3 0 c13[3] 0 1
E13_4 c13b4 0 c13[4] 0 1
E13_5 c13b5 0 c13[5] 0 1
E13_6 c13b6 0 c13[6] 0 1
E13_7 c13b7 0 c13[7] 0 1
E13_8 c13b8 0 c13[8] 0 1
E13_9 c13b9 0 c13[9] 0 1
E13_10 c13b10 0 c13[10] 0 1
E13_11 c13b11 0 c13[11] 0 1
E13_12 c13b12 0 c13[12] 0 1
E13_13 c13b13 0 c13[13] 0 1
E13_14 c13b14 0 c13[14] 0 1
E13_15 c13b15 0 c13[15] 0 1
E13_16 c13b16 0 c13[16] 0 1
E13_17 c13b17 0 c13[17] 0 1
E13_18 c13b18 0 c13[18] 0 1
E13_19 c13b19 0 c13[19] 0 1
E20_0 c20b0 0 c20[0] 0 1
E20_1 c20b1 0 c20[1] 0 1
E20_2 c20b2 0 c20[2] 0 1
E20_3 c20b3 0 c20[3] 0 1
E20_4 c20b4 0 c20[4] 0 1
E20_5 c20b5 0 c20[5] 0 1
E20_6 c20b6 0 c20[6] 0 1
E20_7 c20b7 0 c20[7] 0 1
E20_8 c20b8 0 c20[8] 0 1
E20_9 c20b9 0 c20[9] 0 1
E20_10 c20b10 0 c20[10] 0 1
E20_11 c20b11 0 c20[11] 0 1
E20_12 c20b12 0 c20[12] 0 1
E20_13 c20b13 0 c20[13] 0 1
E20_14 c20b14 0 c20[14] 0 1
E20_15 c20b15 0 c20[15] 0 1
E20_16 c20b16 0 c20[16] 0 1
E20_17 c20b17 0 c20[17] 0 1
E20_18 c20b18 0 c20[18] 0 1
E20_19 c20b19 0 c20[19] 0 1
E21_0 c21b0 0 c21[0] 0 1
E21_1 c21b1 0 c21[1] 0 1
E21_2 c21b2 0 c21[2] 0 1
E21_3 c21b3 0 c21[3] 0 1
E21_4 c21b4 0 c21[4] 0 1
E21_5 c21b5 0 c21[5] 0 1
E21_6 c21b6 0 c21[6] 0 1
E21_7 c21b7 0 c21[7] 0 1
E21_8 c21b8 0 c21[8] 0 1
E21_9 c21b9 0 c21[9] 0 1
E21_10 c21b10 0 c21[10] 0 1
E21_11 c21b11 0 c21[11] 0 1
E21_12 c21b12 0 c21[12] 0 1
E21_13 c21b13 0 c21[13] 0 1
E21_14 c21b14 0 c21[14] 0 1
E21_15 c21b15 0 c21[15] 0 1
E21_16 c21b16 0 c21[16] 0 1
E21_17 c21b17 0 c21[17] 0 1
E21_18 c21b18 0 c21[18] 0 1
E21_19 c21b19 0 c21[19] 0 1
E22_0 c22b0 0 c22[0] 0 1
E22_1 c22b1 0 c22[1] 0 1
E22_2 c22b2 0 c22[2] 0 1
E22_3 c22b3 0 c22[3] 0 1
E22_4 c22b4 0 c22[4] 0 1
E22_5 c22b5 0 c22[5] 0 1
E22_6 c22b6 0 c22[6] 0 1
E22_7 c22b7 0 c22[7] 0 1
E22_8 c22b8 0 c22[8] 0 1
E22_9 c22b9 0 c22[9] 0 1
E22_10 c22b10 0 c22[10] 0 1
E22_11 c22b11 0 c22[11] 0 1
E22_12 c22b12 0 c22[12] 0 1
E22_13 c22b13 0 c22[13] 0 1
E22_14 c22b14 0 c22[14] 0 1
E22_15 c22b15 0 c22[15] 0 1
E22_16 c22b16 0 c22[16] 0 1
E22_17 c22b17 0 c22[17] 0 1
E22_18 c22b18 0 c22[18] 0 1
E22_19 c22b19 0 c22[19] 0 1
E23_0 c23b0 0 c23[0] 0 1
E23_1 c23b1 0 c23[1] 0 1
E23_2 c23b2 0 c23[2] 0 1
E23_3 c23b3 0 c23[3] 0 1
E23_4 c23b4 0 c23[4] 0 1
E23_5 c23b5 0 c23[5] 0 1
E23_6 c23b6 0 c23[6] 0 1
E23_7 c23b7 0 c23[7] 0 1
E23_8 c23b8 0 c23[8] 0 1
E23_9 c23b9 0 c23[9] 0 1
E23_10 c23b10 0 c23[10] 0 1
E23_11 c23b11 0 c23[11] 0 1
E23_12 c23b12 0 c23[12] 0 1
E23_13 c23b13 0 c23[13] 0 1
E23_14 c23b14 0 c23[14] 0 1
E23_15 c23b15 0 c23[15] 0 1
E23_16 c23b16 0 c23[16] 0 1
E23_17 c23b17 0 c23[17] 0 1
E23_18 c23b18 0 c23[18] 0 1
E23_19 c23b19 0 c23[19] 0 1
E30_0 c30b0 0 c30[0] 0 1
E30_1 c30b1 0 c30[1] 0 1
E30_2 c30b2 0 c30[2] 0 1
E30_3 c30b3 0 c30[3] 0 1
E30_4 c30b4 0 c30[4] 0 1
E30_5 c30b5 0 c30[5] 0 1
E30_6 c30b6 0 c30[6] 0 1
E30_7 c30b7 0 c30[7] 0 1
E30_8 c30b8 0 c30[8] 0 1
E30_9 c30b9 0 c30[9] 0 1
E30_10 c30b10 0 c30[10] 0 1
E30_11 c30b11 0 c30[11] 0 1
E30_12 c30b12 0 c30[12] 0 1
E30_13 c30b13 0 c30[13] 0 1
E30_14 c30b14 0 c30[14] 0 1
E30_15 c30b15 0 c30[15] 0 1
E30_16 c30b16 0 c30[16] 0 1
E30_17 c30b17 0 c30[17] 0 1
E30_18 c30b18 0 c30[18] 0 1
E30_19 c30b19 0 c30[19] 0 1
E31_0 c31b0 0 c31[0] 0 1
E31_1 c31b1 0 c31[1] 0 1
E31_2 c31b2 0 c31[2] 0 1
E31_3 c31b3 0 c31[3] 0 1
E31_4 c31b4 0 c31[4] 0 1
E31_5 c31b5 0 c31[5] 0 1
E31_6 c31b6 0 c31[6] 0 1
E31_7 c31b7 0 c31[7] 0 1
E31_8 c31b8 0 c31[8] 0 1
E31_9 c31b9 0 c31[9] 0 1
E31_10 c31b10 0 c31[10] 0 1
E31_11 c31b11 0 c31[11] 0 1
E31_12 c31b12 0 c31[12] 0 1
E31_13 c31b13 0 c31[13] 0 1
E31_14 c31b14 0 c31[14] 0 1
E31_15 c31b15 0 c31[15] 0 1
E31_16 c31b16 0 c31[16] 0 1
E31_17 c31b17 0 c31[17] 0 1
E31_18 c31b18 0 c31[18] 0 1
E31_19 c31b19 0 c31[19] 0 1
E32_0 c32b0 0 c32[0] 0 1
E32_1 c32b1 0 c32[1] 0 1
E32_2 c32b2 0 c32[2] 0 1
E32_3 c32b3 0 c32[3] 0 1
E32_4 c32b4 0 c32[4] 0 1
E32_5 c32b5 0 c32[5] 0 1
E32_6 c32b6 0 c32[6] 0 1
E32_7 c32b7 0 c32[7] 0 1
E32_8 c32b8 0 c32[8] 0 1
E32_9 c32b9 0 c32[9] 0 1
E32_10 c32b10 0 c32[10] 0 1
E32_11 c32b11 0 c32[11] 0 1
E32_12 c32b12 0 c32[12] 0 1
E32_13 c32b13 0 c32[13] 0 1
E32_14 c32b14 0 c32[14] 0 1
E32_15 c32b15 0 c32[15] 0 1
E32_16 c32b16 0 c32[16] 0 1
E32_17 c32b17 0 c32[17] 0 1
E32_18 c32b18 0 c32[18] 0 1
E32_19 c32b19 0 c32[19] 0 1
E33_0 c33b0 0 c33[0] 0 1
E33_1 c33b1 0 c33[1] 0 1
E33_2 c33b2 0 c33[2] 0 1
E33_3 c33b3 0 c33[3] 0 1
E33_4 c33b4 0 c33[4] 0 1
E33_5 c33b5 0 c33[5] 0 1
E33_6 c33b6 0 c33[6] 0 1
E33_7 c33b7 0 c33[7] 0 1
E33_8 c33b8 0 c33[8] 0 1
E33_9 c33b9 0 c33[9] 0 1
E33_10 c33b10 0 c33[10] 0 1
E33_11 c33b11 0 c33[11] 0 1
E33_12 c33b12 0 c33[12] 0 1
E33_13 c33b13 0 c33[13] 0 1
E33_14 c33b14 0 c33[14] 0 1
E33_15 c33b15 0 c33[15] 0 1
E33_16 c33b16 0 c33[16] 0 1
E33_17 c33b17 0 c33[17] 0 1
E33_18 c33b18 0 c33[18] 0 1
E33_19 c33b19 0 c33[19] 0 1
* ===== turn each 20-bit ACC into ONE decimal number =====
Bd00 d00 0 V = 1*u(v(c00b0)-0.9) + 2*u(v(c00b1)-0.9) + 4*u(v(c00b2)-0.9) + 8*u(v(c00b3)-0.9) + 16*u(v(c00b4)-0.9) + 32*u(v(c00b5)-0.9) + 64*u(v(c00b6)-0.9) + 128*u(v(c00b7)-0.9) + 256*u(v(c00b8)-0.9) + 512*u(v(c00b9)-0.9) + 1024*u(v(c00b10)-0.9) + 2048*u(v(c00b11)-0.9) + 4096*u(v(c00b12)-0.9) + 8192*u(v(c00b13)-0.9) + 16384*u(v(c00b14)-0.9) + 32768*u(v(c00b15)-0.9) + 65536*u(v(c00b16)-0.9) + 131072*u(v(c00b17)-0.9) + 262144*u(v(c00b18)-0.9) - 524288*u(v(c00b19)-0.9)
Bd01 d01 0 V = 1*u(v(c01b0)-0.9) + 2*u(v(c01b1)-0.9) + 4*u(v(c01b2)-0.9) + 8*u(v(c01b3)-0.9) + 16*u(v(c01b4)-0.9) + 32*u(v(c01b5)-0.9) + 64*u(v(c01b6)-0.9) + 128*u(v(c01b7)-0.9) + 256*u(v(c01b8)-0.9) + 512*u(v(c01b9)-0.9) + 1024*u(v(c01b10)-0.9) + 2048*u(v(c01b11)-0.9) + 4096*u(v(c01b12)-0.9) + 8192*u(v(c01b13)-0.9) + 16384*u(v(c01b14)-0.9) + 32768*u(v(c01b15)-0.9) + 65536*u(v(c01b16)-0.9) + 131072*u(v(c01b17)-0.9) + 262144*u(v(c01b18)-0.9) - 524288*u(v(c01b19)-0.9)
Bd02 d02 0 V = 1*u(v(c02b0)-0.9) + 2*u(v(c02b1)-0.9) + 4*u(v(c02b2)-0.9) + 8*u(v(c02b3)-0.9) + 16*u(v(c02b4)-0.9) + 32*u(v(c02b5)-0.9) + 64*u(v(c02b6)-0.9) + 128*u(v(c02b7)-0.9) + 256*u(v(c02b8)-0.9) + 512*u(v(c02b9)-0.9) + 1024*u(v(c02b10)-0.9) + 2048*u(v(c02b11)-0.9) + 4096*u(v(c02b12)-0.9) + 8192*u(v(c02b13)-0.9) + 16384*u(v(c02b14)-0.9) + 32768*u(v(c02b15)-0.9) + 65536*u(v(c02b16)-0.9) + 131072*u(v(c02b17)-0.9) + 262144*u(v(c02b18)-0.9) - 524288*u(v(c02b19)-0.9)
Bd03 d03 0 V = 1*u(v(c03b0)-0.9) + 2*u(v(c03b1)-0.9) + 4*u(v(c03b2)-0.9) + 8*u(v(c03b3)-0.9) + 16*u(v(c03b4)-0.9) + 32*u(v(c03b5)-0.9) + 64*u(v(c03b6)-0.9) + 128*u(v(c03b7)-0.9) + 256*u(v(c03b8)-0.9) + 512*u(v(c03b9)-0.9) + 1024*u(v(c03b10)-0.9) + 2048*u(v(c03b11)-0.9) + 4096*u(v(c03b12)-0.9) + 8192*u(v(c03b13)-0.9) + 16384*u(v(c03b14)-0.9) + 32768*u(v(c03b15)-0.9) + 65536*u(v(c03b16)-0.9) + 131072*u(v(c03b17)-0.9) + 262144*u(v(c03b18)-0.9) - 524288*u(v(c03b19)-0.9)
Bd10 d10 0 V = 1*u(v(c10b0)-0.9) + 2*u(v(c10b1)-0.9) + 4*u(v(c10b2)-0.9) + 8*u(v(c10b3)-0.9) + 16*u(v(c10b4)-0.9) + 32*u(v(c10b5)-0.9) + 64*u(v(c10b6)-0.9) + 128*u(v(c10b7)-0.9) + 256*u(v(c10b8)-0.9) + 512*u(v(c10b9)-0.9) + 1024*u(v(c10b10)-0.9) + 2048*u(v(c10b11)-0.9) + 4096*u(v(c10b12)-0.9) + 8192*u(v(c10b13)-0.9) + 16384*u(v(c10b14)-0.9) + 32768*u(v(c10b15)-0.9) + 65536*u(v(c10b16)-0.9) + 131072*u(v(c10b17)-0.9) + 262144*u(v(c10b18)-0.9) - 524288*u(v(c10b19)-0.9)
Bd11 d11 0 V = 1*u(v(c11b0)-0.9) + 2*u(v(c11b1)-0.9) + 4*u(v(c11b2)-0.9) + 8*u(v(c11b3)-0.9) + 16*u(v(c11b4)-0.9) + 32*u(v(c11b5)-0.9) + 64*u(v(c11b6)-0.9) + 128*u(v(c11b7)-0.9) + 256*u(v(c11b8)-0.9) + 512*u(v(c11b9)-0.9) + 1024*u(v(c11b10)-0.9) + 2048*u(v(c11b11)-0.9) + 4096*u(v(c11b12)-0.9) + 8192*u(v(c11b13)-0.9) + 16384*u(v(c11b14)-0.9) + 32768*u(v(c11b15)-0.9) + 65536*u(v(c11b16)-0.9) + 131072*u(v(c11b17)-0.9) + 262144*u(v(c11b18)-0.9) - 524288*u(v(c11b19)-0.9)
Bd12 d12 0 V = 1*u(v(c12b0)-0.9) + 2*u(v(c12b1)-0.9) + 4*u(v(c12b2)-0.9) + 8*u(v(c12b3)-0.9) + 16*u(v(c12b4)-0.9) + 32*u(v(c12b5)-0.9) + 64*u(v(c12b6)-0.9) + 128*u(v(c12b7)-0.9) + 256*u(v(c12b8)-0.9) + 512*u(v(c12b9)-0.9) + 1024*u(v(c12b10)-0.9) + 2048*u(v(c12b11)-0.9) + 4096*u(v(c12b12)-0.9) + 8192*u(v(c12b13)-0.9) + 16384*u(v(c12b14)-0.9) + 32768*u(v(c12b15)-0.9) + 65536*u(v(c12b16)-0.9) + 131072*u(v(c12b17)-0.9) + 262144*u(v(c12b18)-0.9) - 524288*u(v(c12b19)-0.9)
Bd13 d13 0 V = 1*u(v(c13b0)-0.9) + 2*u(v(c13b1)-0.9) + 4*u(v(c13b2)-0.9) + 8*u(v(c13b3)-0.9) + 16*u(v(c13b4)-0.9) + 32*u(v(c13b5)-0.9) + 64*u(v(c13b6)-0.9) + 128*u(v(c13b7)-0.9) + 256*u(v(c13b8)-0.9) + 512*u(v(c13b9)-0.9) + 1024*u(v(c13b10)-0.9) + 2048*u(v(c13b11)-0.9) + 4096*u(v(c13b12)-0.9) + 8192*u(v(c13b13)-0.9) + 16384*u(v(c13b14)-0.9) + 32768*u(v(c13b15)-0.9) + 65536*u(v(c13b16)-0.9) + 131072*u(v(c13b17)-0.9) + 262144*u(v(c13b18)-0.9) - 524288*u(v(c13b19)-0.9)
Bd20 d20 0 V = 1*u(v(c20b0)-0.9) + 2*u(v(c20b1)-0.9) + 4*u(v(c20b2)-0.9) + 8*u(v(c20b3)-0.9) + 16*u(v(c20b4)-0.9) + 32*u(v(c20b5)-0.9) + 64*u(v(c20b6)-0.9) + 128*u(v(c20b7)-0.9) + 256*u(v(c20b8)-0.9) + 512*u(v(c20b9)-0.9) + 1024*u(v(c20b10)-0.9) + 2048*u(v(c20b11)-0.9) + 4096*u(v(c20b12)-0.9) + 8192*u(v(c20b13)-0.9) + 16384*u(v(c20b14)-0.9) + 32768*u(v(c20b15)-0.9) + 65536*u(v(c20b16)-0.9) + 131072*u(v(c20b17)-0.9) + 262144*u(v(c20b18)-0.9) - 524288*u(v(c20b19)-0.9)
Bd21 d21 0 V = 1*u(v(c21b0)-0.9) + 2*u(v(c21b1)-0.9) + 4*u(v(c21b2)-0.9) + 8*u(v(c21b3)-0.9) + 16*u(v(c21b4)-0.9) + 32*u(v(c21b5)-0.9) + 64*u(v(c21b6)-0.9) + 128*u(v(c21b7)-0.9) + 256*u(v(c21b8)-0.9) + 512*u(v(c21b9)-0.9) + 1024*u(v(c21b10)-0.9) + 2048*u(v(c21b11)-0.9) + 4096*u(v(c21b12)-0.9) + 8192*u(v(c21b13)-0.9) + 16384*u(v(c21b14)-0.9) + 32768*u(v(c21b15)-0.9) + 65536*u(v(c21b16)-0.9) + 131072*u(v(c21b17)-0.9) + 262144*u(v(c21b18)-0.9) - 524288*u(v(c21b19)-0.9)
Bd22 d22 0 V = 1*u(v(c22b0)-0.9) + 2*u(v(c22b1)-0.9) + 4*u(v(c22b2)-0.9) + 8*u(v(c22b3)-0.9) + 16*u(v(c22b4)-0.9) + 32*u(v(c22b5)-0.9) + 64*u(v(c22b6)-0.9) + 128*u(v(c22b7)-0.9) + 256*u(v(c22b8)-0.9) + 512*u(v(c22b9)-0.9) + 1024*u(v(c22b10)-0.9) + 2048*u(v(c22b11)-0.9) + 4096*u(v(c22b12)-0.9) + 8192*u(v(c22b13)-0.9) + 16384*u(v(c22b14)-0.9) + 32768*u(v(c22b15)-0.9) + 65536*u(v(c22b16)-0.9) + 131072*u(v(c22b17)-0.9) + 262144*u(v(c22b18)-0.9) - 524288*u(v(c22b19)-0.9)
Bd23 d23 0 V = 1*u(v(c23b0)-0.9) + 2*u(v(c23b1)-0.9) + 4*u(v(c23b2)-0.9) + 8*u(v(c23b3)-0.9) + 16*u(v(c23b4)-0.9) + 32*u(v(c23b5)-0.9) + 64*u(v(c23b6)-0.9) + 128*u(v(c23b7)-0.9) + 256*u(v(c23b8)-0.9) + 512*u(v(c23b9)-0.9) + 1024*u(v(c23b10)-0.9) + 2048*u(v(c23b11)-0.9) + 4096*u(v(c23b12)-0.9) + 8192*u(v(c23b13)-0.9) + 16384*u(v(c23b14)-0.9) + 32768*u(v(c23b15)-0.9) + 65536*u(v(c23b16)-0.9) + 131072*u(v(c23b17)-0.9) + 262144*u(v(c23b18)-0.9) - 524288*u(v(c23b19)-0.9)
Bd30 d30 0 V = 1*u(v(c30b0)-0.9) + 2*u(v(c30b1)-0.9) + 4*u(v(c30b2)-0.9) + 8*u(v(c30b3)-0.9) + 16*u(v(c30b4)-0.9) + 32*u(v(c30b5)-0.9) + 64*u(v(c30b6)-0.9) + 128*u(v(c30b7)-0.9) + 256*u(v(c30b8)-0.9) + 512*u(v(c30b9)-0.9) + 1024*u(v(c30b10)-0.9) + 2048*u(v(c30b11)-0.9) + 4096*u(v(c30b12)-0.9) + 8192*u(v(c30b13)-0.9) + 16384*u(v(c30b14)-0.9) + 32768*u(v(c30b15)-0.9) + 65536*u(v(c30b16)-0.9) + 131072*u(v(c30b17)-0.9) + 262144*u(v(c30b18)-0.9) - 524288*u(v(c30b19)-0.9)
Bd31 d31 0 V = 1*u(v(c31b0)-0.9) + 2*u(v(c31b1)-0.9) + 4*u(v(c31b2)-0.9) + 8*u(v(c31b3)-0.9) + 16*u(v(c31b4)-0.9) + 32*u(v(c31b5)-0.9) + 64*u(v(c31b6)-0.9) + 128*u(v(c31b7)-0.9) + 256*u(v(c31b8)-0.9) + 512*u(v(c31b9)-0.9) + 1024*u(v(c31b10)-0.9) + 2048*u(v(c31b11)-0.9) + 4096*u(v(c31b12)-0.9) + 8192*u(v(c31b13)-0.9) + 16384*u(v(c31b14)-0.9) + 32768*u(v(c31b15)-0.9) + 65536*u(v(c31b16)-0.9) + 131072*u(v(c31b17)-0.9) + 262144*u(v(c31b18)-0.9) - 524288*u(v(c31b19)-0.9)
Bd32 d32 0 V = 1*u(v(c32b0)-0.9) + 2*u(v(c32b1)-0.9) + 4*u(v(c32b2)-0.9) + 8*u(v(c32b3)-0.9) + 16*u(v(c32b4)-0.9) + 32*u(v(c32b5)-0.9) + 64*u(v(c32b6)-0.9) + 128*u(v(c32b7)-0.9) + 256*u(v(c32b8)-0.9) + 512*u(v(c32b9)-0.9) + 1024*u(v(c32b10)-0.9) + 2048*u(v(c32b11)-0.9) + 4096*u(v(c32b12)-0.9) + 8192*u(v(c32b13)-0.9) + 16384*u(v(c32b14)-0.9) + 32768*u(v(c32b15)-0.9) + 65536*u(v(c32b16)-0.9) + 131072*u(v(c32b17)-0.9) + 262144*u(v(c32b18)-0.9) - 524288*u(v(c32b19)-0.9)
Bd33 d33 0 V = 1*u(v(c33b0)-0.9) + 2*u(v(c33b1)-0.9) + 4*u(v(c33b2)-0.9) + 8*u(v(c33b3)-0.9) + 16*u(v(c33b4)-0.9) + 32*u(v(c33b5)-0.9) + 64*u(v(c33b6)-0.9) + 128*u(v(c33b7)-0.9) + 256*u(v(c33b8)-0.9) + 512*u(v(c33b9)-0.9) + 1024*u(v(c33b10)-0.9) + 2048*u(v(c33b11)-0.9) + 4096*u(v(c33b12)-0.9) + 8192*u(v(c33b13)-0.9) + 16384*u(v(c33b14)-0.9) + 32768*u(v(c33b15)-0.9) + 65536*u(v(c33b16)-0.9) + 131072*u(v(c33b17)-0.9) + 262144*u(v(c33b18)-0.9) - 524288*u(v(c33b19)-0.9)

.save v(clk) v(d00) v(d01) v(d02) v(d03) v(d10) v(d11) v(d12) v(d13) v(d20) v(d21) v(d22) v(d23) v(d30) v(d31) v(d32) v(d33)

.control
run
meas tran C00 find v(d00) at=139n
meas tran C01 find v(d01) at=139n
meas tran C02 find v(d02) at=139n
meas tran C03 find v(d03) at=139n
meas tran C10 find v(d10) at=139n
meas tran C11 find v(d11) at=139n
meas tran C12 find v(d12) at=139n
meas tran C13 find v(d13) at=139n
meas tran C20 find v(d20) at=139n
meas tran C21 find v(d21) at=139n
meas tran C22 find v(d22) at=139n
meas tran C23 find v(d23) at=139n
meas tran C30 find v(d30) at=139n
meas tran C31 find v(d31) at=139n
meas tran C32 find v(d32) at=139n
meas tran C33 find v(d33) at=139n
plot v(d00) v(d01) v(d02) v(d03) title 'row 0 of C (decimal)'
plot v(d10) v(d11) v(d12) v(d13) title 'row 1 of C (decimal)'
plot v(d20) v(d21) v(d22) v(d23) title 'row 2 of C (decimal)'
plot v(d30) v(d31) v(d32) v(d33) title 'row 3 of C (decimal)'
.endc
