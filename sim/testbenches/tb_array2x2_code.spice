.include /foss/pdks/sky130A/libs.ref/sky130_fd_sc_hd/spice/sky130_fd_sc_hd.spice
.tran 0.1n 120n uic

* ===== inputs: A rows enter on the left (ah_0), B columns on top (bv0_) =====
* row 0 of A, staircase starts tick 5
Vah00_0 ah00[0] 0 PWL(0 0 36n 0 36.1n 1.8 46n 1.8 46.1n 0)
Vah00_1 ah00[1] 0 PWL(0 0 36n 0 36.1n 1.8 56n 1.8 56.1n 0)
Vah00_2 ah00[2] 0 PWL(0 0 46n 0 46.1n 1.8 56n 1.8 56.1n 0)
Vah00_3 ah00[3] 0 PWL(0 0 46n 0 46.1n 1.8 56n 1.8 56.1n 0)
Vah00_4 ah00[4] 0 PWL(0 0 46n 0 46.1n 1.8 56n 1.8 56.1n 0)
Vah00_5 ah00[5] 0 PWL(0 0 46n 0 46.1n 1.8 56n 1.8 56.1n 0)
Vah00_6 ah00[6] 0 PWL(0 0 46n 0 46.1n 1.8 56n 1.8 56.1n 0)
Vah00_7 ah00[7] 0 PWL(0 0 46n 0 46.1n 1.8 56n 1.8 56.1n 0)
* row 1 of A, staircase starts tick 6
Vah10_0 ah10[0] 0 PWL(0 0 46n 0 46.1n 1.8 56n 1.8 56.1n 0)
Vah10_1 ah10[1] 0 0
Vah10_2 ah10[2] 0 PWL(0 0 56n 0 56.1n 1.8 66n 1.8 66.1n 0)
Vah10_3 ah10[3] 0 0
Vah10_4 ah10[4] 0 0
Vah10_5 ah10[5] 0 0
Vah10_6 ah10[6] 0 0
Vah10_7 ah10[7] 0 0
* column 0 of B, staircase starts tick 5
Vbv00_0 bv00[0] 0 PWL(0 0 46n 0 46.1n 1.8 56n 1.8 56.1n 0)
Vbv00_1 bv00[1] 0 PWL(0 0 36n 0 36.1n 1.8 56n 1.8 56.1n 0)
Vbv00_2 bv00[2] 0 PWL(0 0 46n 0 46.1n 1.8 56n 1.8 56.1n 0)
Vbv00_3 bv00[3] 0 PWL(0 0 46n 0 46.1n 1.8 56n 1.8 56.1n 0)
Vbv00_4 bv00[4] 0 PWL(0 0 46n 0 46.1n 1.8 56n 1.8 56.1n 0)
Vbv00_5 bv00[5] 0 PWL(0 0 46n 0 46.1n 1.8 56n 1.8 56.1n 0)
Vbv00_6 bv00[6] 0 PWL(0 0 46n 0 46.1n 1.8 56n 1.8 56.1n 0)
Vbv00_7 bv00[7] 0 PWL(0 0 46n 0 46.1n 1.8 56n 1.8 56.1n 0)
* column 1 of B, staircase starts tick 6
Vbv01_0 bv01[0] 0 PWL(0 0 46n 0 46.1n 1.8 66n 1.8 66.1n 0)
Vbv01_1 bv01[1] 0 0
Vbv01_2 bv01[2] 0 PWL(0 0 56n 0 56.1n 1.8 66n 1.8 66.1n 0)
Vbv01_3 bv01[3] 0 0
Vbv01_4 bv01[4] 0 0
Vbv01_5 bv01[5] 0 0
Vbv01_6 bv01[6] 0 0
Vbv01_7 bv01[7] 0 0
* ===== plain-name copies of every ACC bit (ngspice can't plot [ ]) =====
E00_0 c00b0 0 c00[0] 0 1
E00_1 c00b1 0 c00[1] 0 1
E00_2 c00b2 0 c00[2] 0 1
E00_3 c00b3 0 c00[3] 0 1
E00_4 c00b4 0 c00[4] 0 1
E00_5 c00b5 0 c00[5] 0 1
E00_6 c00b6 0 c00[6] 0 1
E00_7 c00b7 0 c00[7] 0 1
E00_8 c00b8 0 c00[8] 0 1
E00_9 c00b9 0 c00[9] 0 1
E00_10 c00b10 0 c00[10] 0 1
E00_11 c00b11 0 c00[11] 0 1
E00_12 c00b12 0 c00[12] 0 1
E00_13 c00b13 0 c00[13] 0 1
E00_14 c00b14 0 c00[14] 0 1
E00_15 c00b15 0 c00[15] 0 1
E00_16 c00b16 0 c00[16] 0 1
E00_17 c00b17 0 c00[17] 0 1
E00_18 c00b18 0 c00[18] 0 1
E00_19 c00b19 0 c00[19] 0 1
E01_0 c01b0 0 c01[0] 0 1
E01_1 c01b1 0 c01[1] 0 1
E01_2 c01b2 0 c01[2] 0 1
E01_3 c01b3 0 c01[3] 0 1
E01_4 c01b4 0 c01[4] 0 1
E01_5 c01b5 0 c01[5] 0 1
E01_6 c01b6 0 c01[6] 0 1
E01_7 c01b7 0 c01[7] 0 1
E01_8 c01b8 0 c01[8] 0 1
E01_9 c01b9 0 c01[9] 0 1
E01_10 c01b10 0 c01[10] 0 1
E01_11 c01b11 0 c01[11] 0 1
E01_12 c01b12 0 c01[12] 0 1
E01_13 c01b13 0 c01[13] 0 1
E01_14 c01b14 0 c01[14] 0 1
E01_15 c01b15 0 c01[15] 0 1
E01_16 c01b16 0 c01[16] 0 1
E01_17 c01b17 0 c01[17] 0 1
E01_18 c01b18 0 c01[18] 0 1
E01_19 c01b19 0 c01[19] 0 1
E10_0 c10b0 0 c10[0] 0 1
E10_1 c10b1 0 c10[1] 0 1
E10_2 c10b2 0 c10[2] 0 1
E10_3 c10b3 0 c10[3] 0 1
E10_4 c10b4 0 c10[4] 0 1
E10_5 c10b5 0 c10[5] 0 1
E10_6 c10b6 0 c10[6] 0 1
E10_7 c10b7 0 c10[7] 0 1
E10_8 c10b8 0 c10[8] 0 1
E10_9 c10b9 0 c10[9] 0 1
E10_10 c10b10 0 c10[10] 0 1
E10_11 c10b11 0 c10[11] 0 1
E10_12 c10b12 0 c10[12] 0 1
E10_13 c10b13 0 c10[13] 0 1
E10_14 c10b14 0 c10[14] 0 1
E10_15 c10b15 0 c10[15] 0 1
E10_16 c10b16 0 c10[16] 0 1
E10_17 c10b17 0 c10[17] 0 1
E10_18 c10b18 0 c10[18] 0 1
E10_19 c10b19 0 c10[19] 0 1
E11_0 c11b0 0 c11[0] 0 1
E11_1 c11b1 0 c11[1] 0 1
E11_2 c11b2 0 c11[2] 0 1
E11_3 c11b3 0 c11[3] 0 1
E11_4 c11b4 0 c11[4] 0 1
E11_5 c11b5 0 c11[5] 0 1
E11_6 c11b6 0 c11[6] 0 1
E11_7 c11b7 0 c11[7] 0 1
E11_8 c11b8 0 c11[8] 0 1
E11_9 c11b9 0 c11[9] 0 1
E11_10 c11b10 0 c11[10] 0 1
E11_11 c11b11 0 c11[11] 0 1
E11_12 c11b12 0 c11[12] 0 1
E11_13 c11b13 0 c11[13] 0 1
E11_14 c11b14 0 c11[14] 0 1
E11_15 c11b15 0 c11[15] 0 1
E11_16 c11b16 0 c11[16] 0 1
E11_17 c11b17 0 c11[17] 0 1
E11_18 c11b18 0 c11[18] 0 1
E11_19 c11b19 0 c11[19] 0 1
* ===== turn each 20-bit ACC into ONE decimal number =====
Bd00 d00 0 V = 1*u(v(c00b0)-0.9) + 2*u(v(c00b1)-0.9) + 4*u(v(c00b2)-0.9) + 8*u(v(c00b3)-0.9) + 16*u(v(c00b4)-0.9) + 32*u(v(c00b5)-0.9) + 64*u(v(c00b6)-0.9) + 128*u(v(c00b7)-0.9) + 256*u(v(c00b8)-0.9) + 512*u(v(c00b9)-0.9) + 1024*u(v(c00b10)-0.9) + 2048*u(v(c00b11)-0.9) + 4096*u(v(c00b12)-0.9) + 8192*u(v(c00b13)-0.9) + 16384*u(v(c00b14)-0.9) + 32768*u(v(c00b15)-0.9) + 65536*u(v(c00b16)-0.9) + 131072*u(v(c00b17)-0.9) + 262144*u(v(c00b18)-0.9) - 524288*u(v(c00b19)-0.9)
Bd01 d01 0 V = 1*u(v(c01b0)-0.9) + 2*u(v(c01b1)-0.9) + 4*u(v(c01b2)-0.9) + 8*u(v(c01b3)-0.9) + 16*u(v(c01b4)-0.9) + 32*u(v(c01b5)-0.9) + 64*u(v(c01b6)-0.9) + 128*u(v(c01b7)-0.9) + 256*u(v(c01b8)-0.9) + 512*u(v(c01b9)-0.9) + 1024*u(v(c01b10)-0.9) + 2048*u(v(c01b11)-0.9) + 4096*u(v(c01b12)-0.9) + 8192*u(v(c01b13)-0.9) + 16384*u(v(c01b14)-0.9) + 32768*u(v(c01b15)-0.9) + 65536*u(v(c01b16)-0.9) + 131072*u(v(c01b17)-0.9) + 262144*u(v(c01b18)-0.9) - 524288*u(v(c01b19)-0.9)
Bd10 d10 0 V = 1*u(v(c10b0)-0.9) + 2*u(v(c10b1)-0.9) + 4*u(v(c10b2)-0.9) + 8*u(v(c10b3)-0.9) + 16*u(v(c10b4)-0.9) + 32*u(v(c10b5)-0.9) + 64*u(v(c10b6)-0.9) + 128*u(v(c10b7)-0.9) + 256*u(v(c10b8)-0.9) + 512*u(v(c10b9)-0.9) + 1024*u(v(c10b10)-0.9) + 2048*u(v(c10b11)-0.9) + 4096*u(v(c10b12)-0.9) + 8192*u(v(c10b13)-0.9) + 16384*u(v(c10b14)-0.9) + 32768*u(v(c10b15)-0.9) + 65536*u(v(c10b16)-0.9) + 131072*u(v(c10b17)-0.9) + 262144*u(v(c10b18)-0.9) - 524288*u(v(c10b19)-0.9)
Bd11 d11 0 V = 1*u(v(c11b0)-0.9) + 2*u(v(c11b1)-0.9) + 4*u(v(c11b2)-0.9) + 8*u(v(c11b3)-0.9) + 16*u(v(c11b4)-0.9) + 32*u(v(c11b5)-0.9) + 64*u(v(c11b6)-0.9) + 128*u(v(c11b7)-0.9) + 256*u(v(c11b8)-0.9) + 512*u(v(c11b9)-0.9) + 1024*u(v(c11b10)-0.9) + 2048*u(v(c11b11)-0.9) + 4096*u(v(c11b12)-0.9) + 8192*u(v(c11b13)-0.9) + 16384*u(v(c11b14)-0.9) + 32768*u(v(c11b15)-0.9) + 65536*u(v(c11b16)-0.9) + 131072*u(v(c11b17)-0.9) + 262144*u(v(c11b18)-0.9) - 524288*u(v(c11b19)-0.9)

.save v(clk) v(d00) v(d01) v(d10) v(d11)

.control
run
meas tran C00 find v(d00) at=119n
meas tran C01 find v(d01) at=119n
meas tran C10 find v(d10) at=119n
meas tran C11 find v(d11) at=119n
plot v(d00) v(d01) title 'row 0 of C (decimal)'
plot v(d10) v(d11) title 'row 1 of C (decimal)'
.endc
